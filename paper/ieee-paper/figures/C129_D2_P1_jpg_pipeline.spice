* SPICE netlist generated by Circuit Digitization
C1 N0 N1 1e-6
C2 N2 N3 1e-6
C3 N3 N2 1e-6
C4 N0 N4 1e-6
D5 N1 N3 LEDMOD
D6 N2 N5 LEDMOD
D7 N6 N2 LEDMOD
C8 N7 N8 1e-6
D9 N9 N10 LEDMOD
D10 N11 N9 LEDMOD
D11 N12 N13 LEDMOD
D12 N8 N12 LEDMOD
D13 N14 N15 LEDMOD
C14 N13 N7 1e-6
D15 N2 N16 LEDMOD
D16 N3 N0 LEDMOD
D17 N17 N18 LEDMOD
C18 N10 N11 1e-6
D19 N19 N20 LEDMOD
D21 N23 N2 LEDMOD
D22 N13 N24 DMOD
D23 N25 N10 DMOD
D24 N1 N26 DMOD
D25 N6 N27 DMOD
D27 N28 N29 DMOD
D28 N30 N31 DMOD
D29 N32 N33 DMOD
D31 N21 N34 DMOD
VTEST1 N0 0 DC 5
VRET1 N27 0 DC 0
VTEST2 N7 0 DC 5
VRET2 N24 0 DC 0
VTEST3 N9 0 DC 5
VRET3 N25 0 DC 0
VTEST4 N14 0 DC 5
VRET4 N15 0 DC 0
VTEST5 N17 0 DC 5
VRET5 N18 0 DC 0
VTEST6 N19 0 DC 5
VRET6 N20 0 DC 0
VTEST7 N28 0 DC 5
VRET7 N29 0 DC 0
VTEST8 N30 0 DC 5
VRET8 N31 0 DC 0
VTEST9 N32 0 DC 5
VRET9 N33 0 DC 0
VTEST10 N21 0 DC 5
VRET10 N34 0 DC 0
* injected 10 5V test source(s) (+ground returns) to energize disconnected sub-circuits (illustrative)
.model DMOD D(Is=1e-14 N=1)
.model LEDMOD D(Is=1e-14 N=1.5)
.options rshunt=1e12
* skipped (no SPICE model): andx5, antennax1, crystalx1, diode-thyrectorx1
.op
.end
