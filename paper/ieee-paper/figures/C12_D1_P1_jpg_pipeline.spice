* SPICE netlist generated by Circuit Digitization
D1 N0 N1 DMOD
C2 N2 N3 1e-6
C3 N4 N5 1e-6
D4 N6 N7 LEDMOD
D5 N8 N9 LEDMOD
D7 N11 N12 LEDMOD
C8 N13 N14 1e-6
D9 N15 N16 LEDMOD
D10 N17 N18 LEDMOD
D11 N19 N20 LEDMOD
C13 N23 N24 1e-6
D14 N12 N25 LEDMOD
D16 N0 N27 LEDMOD
D17 N17 N28 LEDMOD
D18 N29 N30 LEDMOD
C20 N32 N30 1e-6
D21 N13 N25 LEDMOD
D22 N33 N10 LEDMOD
D23 N34 N35 LEDMOD
C24 N36 N37 1e-6
D25 N1 N0 LEDMOD
C26 N38 N39 1e-6
C27 N40 N41 1e-6
D29 N43 N44 LEDMOD
D41 N36 N59 LEDMOD
D42 N60 N13 DMOD
D43 N47 N60 DMOD
D44 N11 N19 DMOD
D45 N7 N61 DMOD
D46 N26 N15 DMOD
D47 N62 N63 DMOD
D48 N64 N65 DMOD
D49 N52 N66 DMOD
D50 N5 N67 DMOD
D51 N68 N14 DMOD
D52 N69 N41 DMOD
D53 N70 N54 DMOD
D54 N71 N6 DMOD
D55 N72 N73 DMOD
D56 N74 N26 DMOD
D57 N10 N45 DMOD
D58 N75 N23 DMOD
D59 N76 N29 DMOD
D60 N18 N15 DMOD
D61 N77 N66 DMOD
D62 N5 N41 DMOD
D63 N78 N40 DMOD
D64 N34 N79 DMOD
D65 N65 N80 DMOD
D66 N81 N72 DMOD
D67 N65 N51 DMOD
D68 N59 N82 DMOD
D69 N83 N84 DMOD
D70 N25 N85 DMOD
D71 N86 N32 DMOD
D72 N34 N35 DMOD
D73 N87 N78 DMOD
VTEST1 N0 0 DC 5
VRET1 N27 0 DC 0
VTEST2 N2 0 DC 5
VRET2 N3 0 DC 0
VTEST3 N4 0 DC 5
VRET3 N87 0 DC 0
VTEST4 N6 0 DC 5
VRET4 N71 0 DC 0
VTEST5 N8 0 DC 5
VRET5 N9 0 DC 0
VTEST6 N11 0 DC 5
VRET6 N85 0 DC 0
VTEST7 N15 0 DC 5
VRET7 N74 0 DC 0
VTEST8 N23 0 DC 5
VRET8 N75 0 DC 0
VTEST9 N29 0 DC 5
VRET9 N86 0 DC 0
VTEST10 N33 0 DC 5
VRET10 N45 0 DC 0
VTEST11 N34 0 DC 5
VRET11 N79 0 DC 0
VTEST12 N36 0 DC 5
VRET12 N82 0 DC 0
VTEST13 N38 0 DC 5
VRET13 N39 0 DC 0
VTEST14 N43 0 DC 5
VRET14 N44 0 DC 0
VTEST15 N62 0 DC 5
VRET15 N63 0 DC 0
VTEST16 N64 0 DC 5
VRET16 N51 0 DC 0
VTEST17 N52 0 DC 5
VRET17 N77 0 DC 0
VTEST18 N70 0 DC 5
VRET18 N54 0 DC 0
VTEST19 N72 0 DC 5
VRET19 N81 0 DC 0
VTEST20 N83 0 DC 5
VRET20 N84 0 DC 0
* injected 20 5V test source(s) (+ground returns) to energize disconnected sub-circuits (illustrative)
.model DMOD D(Is=1e-14 N=1)
.model LEDMOD D(Is=1e-14 N=1.5)
.options rshunt=1e12
* skipped (no SPICE model): andx8, crossoverx6, crystalx2
.op
.end
