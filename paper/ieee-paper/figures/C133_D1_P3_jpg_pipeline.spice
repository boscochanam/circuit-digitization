* SPICE netlist generated by Circuit Digitization
D2 N2 N3 LEDMOD
D3 N2 N0 LEDMOD
C4 N3 N4 1e-6
D5 N5 N6 LEDMOD
D6 N7 N8 LEDMOD
D7 N9 N3 LEDMOD
D8 N10 N3 LEDMOD
D10 N3 N13 DMOD
D11 N4 N8 DMOD
D12 N10 N3 DMOD
D13 N11 N7 DMOD
D14 N10 N14 DMOD
D15 N6 N2 DMOD
VTEST1 N2 0 DC 5
VRET1 N14 0 DC 0
* injected 1 5V test source(s) (+ground returns) to energize the circuit (illustrative)
.model DMOD D(Is=1e-14 N=1)
.model LEDMOD D(Is=1e-14 N=1.5)
.options rshunt=1e12
* skipped (no SPICE model): andx1, crystalx1, diacx1
.op
.end
