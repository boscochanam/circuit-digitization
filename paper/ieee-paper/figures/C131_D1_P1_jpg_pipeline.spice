* SPICE netlist generated by Circuit Digitization
L1 N0 N1 1e-3
C2 N2 N3 1e-6
C3 N4 N5 1e-6
C4 N6 N7 1e-6
D6 N9 N10 LEDMOD
D8 N13 N14 LEDMOD
D9 N15 N6 LEDMOD
D10 N16 N17 LEDMOD
D12 N8 N19 DMOD
L13 N20 N21 1e-3
D15 N24 N25 DMOD
D16 N26 N27 DMOD
D17 N28 N29 DMOD
L18 N30 N9 1e-3
D19 N12 N11 DMOD
D20 N31 N32 LEDMOD
D21 N33 N2 DMOD
D22 N34 N35 LEDMOD
D23 N36 N37 DMOD
D27 N16 N17 LEDMOD
D29 N6 N1 LEDMOD
D30 N31 N3 DMOD
D31 N45 N13 DMOD
D32 N46 N34 DMOD
D33 N38 N47 LEDMOD
D34 N48 N49 LEDMOD
D35 N4 N50 DMOD
D36 N51 N52 DMOD
D37 N36 N53 LEDMOD
D38 N30 N5 LEDMOD
D39 N49 N48 DMOD
D40 N10 N20 LEDMOD
D42 N49 N22 DMOD
D43 N43 N42 LEDMOD
D44 N5 N54 DMOD
D45 N1 N55 LEDMOD
VTEST1 N0 0 DC 5
VRET1 N55 0 DC 0
VTEST2 N2 0 DC 5
VRET2 N33 0 DC 0
VTEST3 N4 0 DC 5
VRET3 N54 0 DC 0
VTEST4 N13 0 DC 5
VRET4 N45 0 DC 0
VTEST5 N16 0 DC 5
VRET5 N17 0 DC 0
VTEST6 N8 0 DC 5
VRET6 N19 0 DC 0
VTEST7 N24 0 DC 5
VRET7 N25 0 DC 0
VTEST8 N26 0 DC 5
VRET8 N27 0 DC 0
VTEST9 N28 0 DC 5
VRET9 N29 0 DC 0
VTEST10 N12 0 DC 5
VRET10 N11 0 DC 0
VTEST11 N34 0 DC 5
VRET11 N46 0 DC 0
VTEST12 N36 0 DC 5
VRET12 N53 0 DC 0
VTEST13 N38 0 DC 5
VRET13 N47 0 DC 0
VTEST14 N48 0 DC 5
VRET14 N22 0 DC 0
VTEST15 N51 0 DC 5
VRET15 N52 0 DC 0
VTEST16 N43 0 DC 5
VRET16 N42 0 DC 0
* injected 16 5V test source(s) (+ground returns) to energize disconnected sub-circuits (illustrative)
.model DMOD D(Is=1e-14 N=1)
.model LEDMOD D(Is=1e-14 N=1.5)
.options rshunt=1e12
* skipped (no SPICE model): andx2, antennax2, crystalx4, diacx1
.op
.end
