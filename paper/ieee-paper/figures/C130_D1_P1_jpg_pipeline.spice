* SPICE netlist generated by Circuit Digitization
D2 N0 N1 LEDMOD
D3 N2 N3 LEDMOD
D4 N4 N5 LEDMOD
D5 N0 N6 LEDMOD
L6 N7 N8 1e-3
D7 N9 N10 LEDMOD
D8 N11 N12 LEDMOD
D9 N0 N13 LEDMOD
D11 N16 N7 LEDMOD
D12 N17 N15 LEDMOD
D13 N0 N6 LEDMOD
C15 N0 N6 1e-6
D16 N18 N19 DMOD
D17 N20 N17 LEDMOD
C18 N10 N9 1e-6
D19 N21 N11 DMOD
D21 N9 N22 DMOD
D23 N25 N26 DMOD
D25 N27 N28 DMOD
D27 N0 N29 DMOD
D28 N30 N31 DMOD
D29 N6 N25 DMOD
D30 N32 N19 DMOD
D31 N0 N33 DMOD
D32 N18 N34 LEDMOD
D33 N35 N14 DMOD
VTEST1 N0 0 DC 5
VRET1 N33 0 DC 0
VTEST2 N2 0 DC 5
VRET2 N3 0 DC 0
VTEST3 N4 0 DC 5
VRET3 N5 0 DC 0
VTEST4 N7 0 DC 5
VRET4 N16 0 DC 0
VTEST5 N9 0 DC 5
VRET5 N22 0 DC 0
VTEST6 N11 0 DC 5
VRET6 N21 0 DC 0
VTEST7 N17 0 DC 5
VRET7 N20 0 DC 0
VTEST8 N18 0 DC 5
VRET8 N34 0 DC 0
VTEST9 N27 0 DC 5
VRET9 N28 0 DC 0
VTEST10 N30 0 DC 5
VRET10 N31 0 DC 0
VTEST11 N35 0 DC 5
VRET11 N14 0 DC 0
* injected 11 5V test source(s) (+ground returns) to energize disconnected sub-circuits (illustrative)
.model DMOD D(Is=1e-14 N=1)
.model LEDMOD D(Is=1e-14 N=1.5)
.options rshunt=1e12
* skipped (no SPICE model): andx3, antennax2, crossoverx1, diode-thyrectorx1
.op
.end
