* SPICE netlist generated by Circuit Digitization
D1 N0 N1 LEDMOD
D3 N0 N4 DMOD
D5 N3 N2 LEDMOD
D6 N5 N6 LEDMOD
D7 N8 N9 DMOD
D8 N4 N10 DMOD
D9 N11 N12 DMOD
D10 N5 N13 DMOD
D11 N0 N1 LEDMOD
VTEST1 N0 0 DC 5
VRET1 N10 0 DC 0
VTEST2 N3 0 DC 5
VRET2 N2 0 DC 0
VTEST3 N5 0 DC 5
VRET3 N13 0 DC 0
VTEST4 N8 0 DC 5
VRET4 N9 0 DC 0
VTEST5 N11 0 DC 5
VRET5 N12 0 DC 0
* injected 5 5V test source(s) (+ground returns) to energize disconnected sub-circuits (illustrative)
.model DMOD D(Is=1e-14 N=1)
.model LEDMOD D(Is=1e-14 N=1.5)
.options rshunt=1e12
* skipped (no SPICE model): andx1, crystalx1
.op
.end
