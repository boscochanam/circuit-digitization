* SPICE netlist generated by Circuit Digitization
D1 N0 N1 LEDMOD
D2 N2 N3 LEDMOD
D3 N4 N5 LEDMOD
C4 N4 N6 1e-6
L5 N7 N8 1e-3
D7 N9 N10 DMOD
D8 N8 N11 DMOD
D10 N14 N15 DMOD
D11 N16 N17 DMOD
D12 N18 N19 LEDMOD
VTEST1 N0 0 DC 5
VRET1 N1 0 DC 0
VTEST2 N2 0 DC 5
VRET2 N3 0 DC 0
VTEST3 N4 0 DC 5
VRET3 N6 0 DC 0
VTEST4 N7 0 DC 5
VRET4 N11 0 DC 0
VTEST5 N9 0 DC 5
VRET5 N10 0 DC 0
VTEST6 N14 0 DC 5
VRET6 N15 0 DC 0
VTEST7 N16 0 DC 5
VRET7 N17 0 DC 0
VTEST8 N18 0 DC 5
VRET8 N19 0 DC 0
* injected 8 5V test source(s) (+ground returns) to energize disconnected sub-circuits (illustrative)
.model DMOD D(Is=1e-14 N=1)
.model LEDMOD D(Is=1e-14 N=1.5)
.options rshunt=1e12
* skipped (no SPICE model): andx1, diacx1
.op
.end
