* SPICE netlist generated by Circuit Digitization
D2 N1 N2 LEDMOD
D3 N3 N4 LEDMOD
L4 N5 N6 1e-3
C5 N4 N7 1e-6
D6 N8 N9 LEDMOD
D7 N10 N5 LEDMOD
C8 N11 N12 1e-6
D9 N13 N14 LEDMOD
D10 N3 N15 LEDMOD
D12 N16 N19 LEDMOD
D13 0 N20 LEDMOD
D14 N21 N11 DMOD
D15 N10 N22 DMOD
D16 N19 N23 DMOD
D17 N8 N24 LEDMOD
D18 N25 N26 DMOD
C19 N27 N28 1e-6
D20 N29 N6 DMOD
D21 N8 N24 LEDMOD
D22 N12 N30 DMOD
D24 N33 N34 DMOD
D25 N35 N36 DMOD
D26 N36 N29 LEDMOD
D28 N3 N27 LEDMOD
D29 N10 N37 DMOD
C30 N38 N33 1e-6
D31 N19 N39 DMOD
D32 N8 N40 DMOD
C33 N41 N13 1e-6
D34 0 N20 LEDMOD
D35 N6 N36 LEDMOD
D37 N33 N42 DMOD
C38 N40 N27 1e-6
D39 N7 N43 DMOD
D40 N44 N45 DMOD
D41 N1 N4 DMOD
D42 N46 N1 DMOD
D43 N36 N35 DMOD
D44 N47 N28 DMOD
D45 N1 N46 DMOD
D46 N48 N20 DMOD
D47 N3 N15 LEDMOD
D49 N52 N53 DMOD
D50 N54 N55 LEDMOD
D51 N55 N54 LEDMOD
VTEST1 N1 0 DC 5
VRET1 N47 0 DC 0
VTEST2 N5 0 DC 5
VRET2 N37 0 DC 0
VTEST3 N11 0 DC 5
VRET3 N30 0 DC 0
VTEST4 N13 0 DC 5
VRET4 N41 0 DC 0
VTEST5 N16 0 DC 5
VRET5 N39 0 DC 0
VTEST6 N20 0 DC 5
VTEST7 N25 0 DC 5
VRET7 N26 0 DC 0
VTEST8 N33 0 DC 5
VRET8 N42 0 DC 0
VTEST9 N44 0 DC 5
VRET9 N45 0 DC 0
VTEST10 N52 0 DC 5
VRET10 N53 0 DC 0
VTEST11 N54 0 DC 5
VRET11 N55 0 DC 0
* injected 11 5V test source(s) (+ground returns) to energize disconnected sub-circuits (illustrative)
.model DMOD D(Is=1e-14 N=1)
.model LEDMOD D(Is=1e-14 N=1.5)
.options rshunt=1e12
* skipped (no SPICE model): andx3, antennax1, diode-thyrectorx1
.op
.end
