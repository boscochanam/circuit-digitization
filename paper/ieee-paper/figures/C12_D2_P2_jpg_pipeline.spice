* SPICE netlist generated by Circuit Digitization
C1 N0 N1 1e-6
D2 N2 N3 LEDMOD
C3 N4 N5 1e-6
D4 N6 N7 DMOD
D5 N8 N9 LEDMOD
D6 N3 N10 LEDMOD
C7 N11 N12 1e-6
C8 N13 N14 1e-6
D9 N15 N16 LEDMOD
C11 N19 N20 1e-6
D12 N21 N15 LEDMOD
D13 N22 N23 LEDMOD
C14 N24 N25 1e-6
D15 N11 N26 LEDMOD
D16 N27 N21 LEDMOD
D17 N6 N28 LEDMOD
D20 N32 N17 LEDMOD
D23 N37 N13 LEDMOD
C25 N40 N41 1e-6
D27 N43 N35 LEDMOD
D28 N39 N8 LEDMOD
C33 N32 N48 1e-6
D35 N44 N50 DMOD
D36 N10 N51 DMOD
D37 N52 N53 DMOD
D38 N54 N55 DMOD
D39 N46 N56 DMOD
D40 N2 N3 DMOD
D41 N57 N58 DMOD
D42 N59 N29 DMOD
D43 N23 N46 DMOD
D44 N60 N61 DMOD
D45 N52 N62 DMOD
D46 N4 N57 DMOD
D47 N50 N62 DMOD
D48 N22 N63 DMOD
D49 N64 N55 DMOD
D50 N60 N65 DMOD
C52 N67 N68 1e-6
D53 N49 N17 DMOD
D54 N8 N69 DMOD
D55 N4 N70 DMOD
D56 N4 N71 DMOD
D57 N64 N55 DMOD
D58 N33 N72 DMOD
D60 N43 N34 DMOD
D61 N73 N24 LEDMOD
D62 N38 N8 DMOD
D63 N33 N72 DMOD
D64 N74 N37 DMOD
D65 N75 N67 DMOD
D66 N73 N76 DMOD
D68 N19 N27 LEDMOD
D69 N75 N67 DMOD
D70 N33 N78 DMOD
VTEST1 N0 0 DC 5
VRET1 N1 0 DC 0
VTEST2 N2 0 DC 5
VRET2 N51 0 DC 0
VTEST3 N4 0 DC 5
VRET3 N71 0 DC 0
VTEST4 N6 0 DC 5
VRET4 N28 0 DC 0
VTEST5 N8 0 DC 5
VRET5 N38 0 DC 0
VTEST6 N11 0 DC 5
VRET6 N26 0 DC 0
VTEST7 N13 0 DC 5
VRET7 N74 0 DC 0
VTEST8 N15 0 DC 5
VRET8 N27 0 DC 0
VTEST9 N22 0 DC 5
VRET9 N63 0 DC 0
VTEST10 N24 0 DC 5
VRET10 N76 0 DC 0
VTEST11 N32 0 DC 5
VRET11 N49 0 DC 0
VTEST12 N40 0 DC 5
VRET12 N41 0 DC 0
VTEST13 N43 0 DC 5
VRET13 N34 0 DC 0
VTEST14 N44 0 DC 5
VRET14 N62 0 DC 0
VTEST15 N54 0 DC 5
VRET15 N64 0 DC 0
VTEST16 N59 0 DC 5
VRET16 N29 0 DC 0
VTEST17 N60 0 DC 5
VRET17 N65 0 DC 0
VTEST18 N67 0 DC 5
VRET18 N75 0 DC 0
VTEST19 N33 0 DC 5
VRET19 N78 0 DC 0
* injected 19 5V test source(s) (+ground returns) to energize disconnected sub-circuits (illustrative)
.model DMOD D(Is=1e-14 N=1)
.model LEDMOD D(Is=1e-14 N=1.5)
.options rshunt=1e12
* skipped (no SPICE model): andx8, crossoverx5, crystalx2
.op
.end
