* SPICE netlist generated by Circuit Digitization
D2 N1 N2 LEDMOD
D3 N3 N4 LEDMOD
D4 N5 N6 LEDMOD
D5 N7 N8 LEDMOD
D6 N9 N10 LEDMOD
C7 N8 N11 1e-6
D9 N15 N16 LEDMOD
D10 N5 N17 DMOD
D11 N18 N19 DMOD
D12 N20 N4 DMOD
D13 N21 0 LEDMOD
D14 N6 N17 LEDMOD
D15 N4 N5 DMOD
D16 N22 N23 DMOD
C17 N18 N24 1e-6
D18 0 N25 LEDMOD
D19 N26 N27 DMOD
D20 N28 N6 DMOD
D21 N24 N29 DMOD
D22 N12 N26 LEDMOD
C23 N30 N31 1e-6
D25 N34 N35 LEDMOD
D26 N7 0 LEDMOD
D27 N36 N31 DMOD
D28 N15 N34 LEDMOD
D29 N37 N38 DMOD
D30 0 N25 LEDMOD
D32 N8 N3 DMOD
C33 N39 N35 1e-6
D34 N40 N41 DMOD
D35 N35 N42 DMOD
D36 N30 N43 DMOD
D37 N26 N44 DMOD
D38 N45 N46 DMOD
D39 N28 N6 DMOD
D40 N47 N11 DMOD
D41 N48 N49 DMOD
C42 N45 N39 1e-6
D43 N7 N50 DMOD
D44 N51 N10 DMOD
D45 N51 N10 DMOD
C46 N1 N2 1e-6
D47 N7 0 LEDMOD
D48 N21 0 LEDMOD
L49 N3 N5 1e-3
D51 N55 N56 LEDMOD
VTEST1 N1 0 DC 5
VRET1 N2 0 DC 0
VTEST2 N3 0 DC 5
VTEST3 N9 0 DC 5
VRET3 N51 0 DC 0
VTEST4 N15 0 DC 5
VRET4 N46 0 DC 0
VTEST5 N18 0 DC 5
VRET5 N29 0 DC 0
VTEST6 N22 0 DC 5
VRET6 N23 0 DC 0
VTEST7 N26 0 DC 5
VRET7 N44 0 DC 0
VTEST8 N30 0 DC 5
VRET8 N43 0 DC 0
VTEST9 N37 0 DC 5
VRET9 N38 0 DC 0
VTEST10 N40 0 DC 5
VRET10 N41 0 DC 0
VTEST11 N48 0 DC 5
VRET11 N49 0 DC 0
VTEST12 N55 0 DC 5
VRET12 N56 0 DC 0
* injected 12 5V test source(s) (+ground returns) to energize disconnected sub-circuits (illustrative)
.model DMOD D(Is=1e-14 N=1)
.model LEDMOD D(Is=1e-14 N=1.5)
.options rshunt=1e12
* skipped (no SPICE model): andx4, antennax1
.op
.end
